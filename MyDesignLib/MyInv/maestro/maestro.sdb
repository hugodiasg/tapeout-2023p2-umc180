ADE simulation setup
Run mode: Monte Carlo Sampling
Tests:
  MyDesignLib:MyInv:1: MyDesignLib/MyInv/schematic, simulator spectre
