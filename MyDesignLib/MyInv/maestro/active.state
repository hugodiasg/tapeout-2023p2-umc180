ADE simulation setup
Test MyDesignLib:MyInv:1: MyDesignLib/MyInv/schematic, simulator spectre
  Models: /home/hugodg/umc180_skel/UMC_18_CMOS/../Models/Spectre/mm180_bjt_v121.lib.scs[tt_bip], /home/hugodg/umc180_skel/UMC_18_CMOS/../Models/Spectre/mm180_mimcap_v101.lib.scs[mimcaps_typ], /home/hugodg/umc180_skel/UMC_18_CMOS/../Models/Spectre/mm180_reg18bpw_v123.lib.scs[tt], /home/hugodg/umc180_skel/UMC_18_CMOS/../Models/Spectre/mm180_reg33bpw_v123.lib.scs[tt], /home/hugodg/umc180_skel/UMC_18_CMOS/../Models/Spectre/mm180_res_v142.lib.scs[tt], /home/hugodg/umc180_skel/UMC_18_CMOS/../Models/Spectre/mm180_lvt18_v113.lib.scs[tt], /home/hugodg/umc180_skel/UMC_18_CMOS/../Models/Spectre/mm180_lvt33_v113.lib.scs[tt], /home/hugodg/umc180_skel/UMC_18_CMOS/../Models/Spectre/mm180_reg18_v124.lib.scs[tt], /home/hugodg/umc180_skel/UMC_18_CMOS/../Models/Spectre/mm180_reg33_v114.lib.scs[tt], /home/hugodg/umc180_skel/UMC_18_CMOS/../Models/Spectre/mm180_zvt18_v121.lib.scs[tt], /home/hugodg/umc180_skel/UMC_18_CMOS/../Models/Spectre/mm180_zvt33_v113.lib.scs[tt], /home/hugodg/umc180_skel/UMC_18_CMOS/../Models/Spectre/core_rf_v2d4.lib.scs[tt], /home/hugodg/umc180_skel/UMC_18_CMOS/../Models/Spectre/io_rf_v2d3.lib.scs[tt], /home/hugodg/umc180_skel/UMC_18_CMOS/../Models/Spectre/l_slcr20k_rf_v2d3.lib.scs[typ], /home/hugodg/umc180_skel/UMC_18_CMOS/../Models/Spectre/mimcapm_rf_v2d3.lib.scs[typ], /home/hugodg/umc180_skel/UMC_18_CMOS/../Models/Spectre/pad_rf_v2d3.lib.scs[typ], /home/hugodg/umc180_skel/UMC_18_CMOS/../Models/Spectre/rnhr_rf_v2d4.lib.scs[typ], /home/hugodg/umc180_skel/UMC_18_CMOS/../Models/Spectre/rnnpo_rf_v2d4.lib.scs[typ], /home/hugodg/umc180_skel/UMC_18_CMOS/../Models/Spectre/rnppo_rf_v2d4.lib.scs[typ], /home/hugodg/umc180_skel/UMC_18_CMOS/../Models/Spectre/vardiop_rf_v2d3.lib.scs[typ], /home/hugodg/umc180_skel/UMC_18_CMOS/../Models/Spectre/varmis_18_rf_v2d3.lib.scs[typ], /home/hugodg/umc180_skel/UMC_18_CMOS/../Models/Spectre/mm180_diode_v113.mdl.scs
  Temperature: 27
  Analysis tran: stop=50n
Run mode: Monte Carlo Sampling
