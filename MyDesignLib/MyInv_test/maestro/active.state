ADE simulation setup
Test MyDesignLib:MyInv_test:1: MyDesignLib/MyInv_test/schematic, simulator spectre
  Models: /home/hugodg/umc180_skel/Models/Spectre/Monte_Carlo/mm18-mc-spectre-control-v132.lib.scs[mc]
  Variables: sigma = 3
  Temperature: 27
  Analysis tran: stop=50n
  Signals: /net3 as out
Run mode: Monte Carlo Sampling
Monte Carlo Sampling options: mcmethod=mismatch, mcnumpoints=200
