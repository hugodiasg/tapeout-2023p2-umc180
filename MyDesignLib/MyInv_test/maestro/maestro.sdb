ADE simulation setup
Run mode: Monte Carlo Sampling
Tests:
  MyDesignLib:MyInv_test:1: MyDesignLib/MyInv_test/schematic, simulator spectre
    Variables: sigma = 3
Monte Carlo Sampling options: mcmethod=mismatch, mcnumpoints=200
