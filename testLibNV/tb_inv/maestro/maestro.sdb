ADE simulation setup
Run mode: Single Run, Sweeps and Corners
Tests:
  tb_inv_tran: testLibNV/tb_inv/schematic, simulator spectre
  tb_inv_tran_pex: testLibNV/tb_inv/config, simulator spectre
